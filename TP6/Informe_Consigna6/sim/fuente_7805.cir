* Simulacion SPICE Consigna 6 - Fuente con LM7805 y Preregulador Serie
* UTN FRC - Electronica Aplicada II - Grupo 6

* ==============================================================================
* SUBCIRCUITO MACROMODELO LM7805C (Calibrado según hoja de datos TI uA7805C Fig. 6-59)
* - Vo = 5.000 V @ Vi = 10 V, Io = 500 mA, Tj = 25 C
* - Regulación de línea:
*     * Vi = 8 V a 12 V (dVi = 4 V): dVo = 1.0 mV (típico hoja de datos)
*     * Vi = 7 V a 25 V (dVi = 18 V): dVo = 3.2 mV (típico hoja de datos)
* - Dropout: Vdo = 2.0 V @ Io = 1 A (Vi_min = 7.0 V)
* - Regulación de carga: Ro = 0.017 ohm (dVo = 15 mV para dIo = 5 mA a 1.0 A; 5 mV de 250 mA a 750 mA)
* - Corriente de polarización (Bias current): Id = 4.2 mA @ Vi = 10 V (dId = 0.8 mA de 8 V a 25 V)
* - Rechazo de ripple (RR): 78 dB @ 100-120 Hz (atenuación 1/7943 = 1.26e-4 V/V)
* - Limitación de cortocircuito y SOA: Isc = 1.5 A
* ==============================================================================
.SUBCKT LM7805C IN GND OUT
I_BIAS IN GND DC 4.16m
R_BIAS IN GND 22k
* Tensión interna con característica de regulación de línea, transición suave de dropout y clamp en 0 V
B_VO_RAW N_RAW GND V = 0.5 * ( (5.0085 + 0.00025*(V(IN,GND)-10.0) + 0.000010*(V(IN,GND)-10.0)*abs(V(IN,GND)-10.0)) + (V(IN,GND)-1.92) - sqrt(pow((5.0085 + 0.00025*(V(IN,GND)-10.0) + 0.000010*(V(IN,GND)-10.0)*abs(V(IN,GND)-10.0)) - (V(IN,GND)-1.92), 2) + 0.012) )
B_VO INT_REF GND V = V(N_RAW,GND) > 0.0 ? V(N_RAW,GND) : 0.0
R_OUT INT_REF OUT_INT 0.017
B_LIM OUT_INT OUT V = I(B_LIM) > 1.35 ? (I(B_LIM)-1.35)*20.0 : 0.0
B_PASS IN GND I = I(B_LIM) > 0 ? I(B_LIM) : 0
.ENDS LM7805C

* ==============================================================================
* MODELOS DE SEMICONDUCTORES DISCRETOS (Apéndices 1 y 2 de Cátedra)
* ==============================================================================
* Diodo Zener 1N4740A / 1N5240B (Vz = 10.0 V nominal @ Izt = 25 mA, Zzt = 7 ohm)
.MODEL DZ10V D(IS=1.5e-12 RS=4.0 N=1.0 BV=9.92 IBV=25m)
* Diodo Zener 1N4741A / 1N5241B (Vz = 10.8..11.0 V nominal -> Vi_reg = 10.0 V @ Vin=25 V)
.MODEL DZ11V D(IS=1.5e-12 RS=4.0 N=1.0 BV=10.68 IBV=25m)

* Transistor de Paso NPN TIP31C (TO-220, Vceo=100V, Ic=3A, Pc=40W, hFE=85..100)
.MODEL QTIP31C NPN(IS=1.2e-12 BF=90 NF=1.0 VAF=85 IKF=2.5 ISE=5e-12 NE=1.5 BR=4 NR=1.0 RB=0.5 RC=0.05 RE=0.03 CJE=250p CJC=120p TF=25n)

* ==============================================================================
* CIRCUITOS PARA BARRIDO DE LÍNEA Y PUNTO DE OPERACIÓN (RL = 10 ohm -> IL = 500 mA)
* ==============================================================================
V_IN N_IN 0 DC 25.0 AC 1.0 SIN(25.0 1.0 100)

* Circuito A: Con Preregulador Zener 10 V (1N4740A / 1N5240B) y Rz = 180 ohm (Rango extendido 10V-25V)
R_ZA N_IN N_BA 180
D_ZA 0 N_BA DZ10V
Q_1A N_IN N_BA N_IREGA QTIP31C
C_1A N_IREGA 0 330n
X_REG_A N_IREGA 0 N_OUTA LM7805C
C_2A N_OUTA 0 100n
C_3A N_OUTA 0 10u
R_LA N_OUTA 0 10.0

* Circuito B: Con Preregulador Zener 10V (1N5240B) y Rz = 430 ohm (Criterio Secc. 6-9-5h @ Vin=25V)
R_ZB N_IN N_BB 430
D_ZB 0 N_BB DZ10V
Q_1B N_IN N_BB N_IREGB QTIP31C
C_1B N_IREGB 0 330n
X_REG_B N_IREGB 0 N_OUTB LM7805C
C_2B N_OUTB 0 100n
C_3B N_OUTB 0 10u
R_LB N_OUTB 0 10.0

* Circuito C: LM7805C Directo SIN etapa prereguladora (Conexión directa a Vin)
C_1C N_IN 0 330n
X_REG_C N_IN 0 N_OUTC LM7805C
C_2C N_OUTC 0 100n
C_3C N_OUTC 0 10u
R_LC N_OUTC 0 10.0

* Circuito D: Para barrido de Corriente de Carga IL de 0 A a 1.6 A (en Vin = 25 V)
R_ZD N_IN N_BD 180
D_ZD 0 N_BD DZ10V
Q_1D N_IN N_BD N_IREGD QTIP31C
C_1D N_IREGD 0 330n
X_REG_D N_IREGD 0 N_OUTD LM7805C
C_2D N_OUTD 0 100n
V_MEAS_D N_OUTD N_LOAD_D DC 0
I_LOAD N_LOAD_D 0 DC 0.500

.CONTROL
set wr_singlescale
set wr_vecnames

* 1. Barrido DC de Tensión de Entrada Vin de 0 V a 30 V (paso 0.25 V)
dc V_IN 0 30 0.25
wrdata raw_regulacion_linea.txt v(N_BA) v(N_IREGA) v(N_OUTA) v(N_BB) v(N_IREGB) v(N_OUTB) v(N_OUTC)

* 2. Barrido DC de Corriente de Carga I_LOAD de 0.005 A a 1.60 A (paso 0.015 A) con Vin = 25 V
alter V_IN = 25.0
dc I_LOAD 0.005 1.60 0.015
wrdata raw_regulacion_carga.txt v(N_BD) v(N_IREGD) v(N_OUTD)

* 3. Análisis Transitorio con Ripple de Entrada de 2 Vpp (1.0 V pico @ 100 Hz) sobre Vin = 25 V
tran 0.05m 20m 0 0.05m
wrdata raw_ripple_tran.txt v(N_IN) v(N_BA) v(N_IREGA) v(N_OUTA) v(N_OUTC)

quit
.ENDC
.END
