* Ecualizador de 3 bandas - respuesta en frecuencia (salida EQOUT, entrada 1 V en L y R)
* caso 1: los tres potes al medio (plano)
* caso 2/3: graves al maximo / minimo   caso 4/5: medios al maximo / minimo   caso 6/7: agudos al maximo / minimo
.include eq_audio.inc
.param tolr=0 tolc=0
.step param caso 1 7 1
.param gb = if(caso==2,1,if(caso==3,0,0.5))
.param gm = if(caso==4,1,if(caso==5,0,0.5))
.param gt = if(caso==6,1,if(caso==7,0,0.5))

VINL INL 0 AC 1
VINR INR 0 AC 1

* El modelo del TL08x no converge con Gmin stepping: se saltea y LTspice usa source stepping (mismo resultado, 8 veces mas rapido)
.options gminsteps=0
.ac dec 50 10 100k
.save V(EQOUT)
.meas AC g50 FIND mag(V(EQOUT)) AT 50
.meas AC g1k FIND mag(V(EQOUT)) AT 1k
.meas AC g10k FIND mag(V(EQOUT)) AT 10k
.meas AC gmax MAX mag(V(EQOUT)) FROM 20 TO 20k
.meas AC gmin MIN mag(V(EQOUT)) FROM 20 TO 20k
.end
